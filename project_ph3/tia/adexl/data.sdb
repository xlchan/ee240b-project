ADE simulation setup
Run mode: Single Run, Sweeps and Corners
Tests:
  project_ph3:tia:1: project_ph3/tia/schematic, simulator spectre
    Outputs: Rdc; Vout; Vin; Iph; BW
Global variables:
  tsim = 5*tper
  cin = 20f
  cload = 40f
  isw = 10u
  nfn = 1.71
  nfp = 2.29
  rf = 3.73k
  tper = 200p
  vdd = 1.2
  tdelay = tper/2
  trise = 20p
