ADE simulation setup
Run mode: Single Run, Sweeps and Corners
Tests:
  project_ph3:strongarm_tb:1: project_ph3/strongarm_tb/schematic, simulator spectre
    Outputs: vo_diff; vi_diff; vff_diff; clk; vi; vcm; clk_B
Global variables:
  nfp_sa = 1.2
  nfn_sa = 3
  nfi = 22.8
  nft = 22.8
  nfs = 2
  nfn_sr = 1
  nfp_sr = 1
  nfp_buff = 1
  nfn_buff = 1
  nfp_inv = 10
  nfn_inv = 5
  vin1 = -vdd/2
  vin2 = 20m
  vodc = 600m
  voff = -300m
  vamp = {From/To}Linear:50m:100m:600m{From/To}
  vref = 600m
  voff_bot = 6.11m
  voff_top = 16.84m
  vdd = 1.2
  cff = 5f
  t_delay = t_per/2
  t_per = 200p
  t_rise = 20p
  t_sim = 9*t_per
