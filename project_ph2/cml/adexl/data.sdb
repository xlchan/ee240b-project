ADE simulation setup
Run mode: Single Run, Sweeps and Corners
Tests:
  project_ph2:cml:1: project_ph2/cml/schematic, simulator spectre
    Outputs: vout; curr_in; curr_xc
Global variables:
  rload = 664k
  idc = 1.23u*2
  vin = 20m
  nf_in = 1.23
  nf_xc = 1
  nf_sw = 20
