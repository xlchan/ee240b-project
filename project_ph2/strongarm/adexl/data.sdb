ADE simulation setup
Run mode: Single Run, Sweeps and Corners
Tests:
  project_ph2:strongarm:1: project_ph2/strongarm/schematic, simulator spectre
    Outputs: /clk; /vin+; /vin-; vo_diff; "/V1/PLUS"; J/bit; int_curr; vo_setup; vi_diff
Global variables:
  nfp_sa = 1.2
  nfx = 3
  nfn_sa = 22.8
  nft = 22.8
  nfsw = 2
  vin = 100m
  vref = 600m
  vin1 = -vdd/2
  vin2 = {From/To}Linear:15m:1m:25m{From/To}
  vcm = 600m
  voff_bot = 6.11m
  voff_top = 16.84m
  t_per = 200p
  t_sim = 8*t_per
  t_delay = t_per/2
  t_rise = 20p
  cff = 5f
  vdd = 1.2
