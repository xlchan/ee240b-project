ADE simulation setup
Run mode: Single Run, Sweeps and Corners
Tests:
  project_ph2:comparator_strongarm:1: project_ph2/comparator_strongarm/schematic, simulator spectre
    Outputs: /clk; /vin+; /vin-; vo_diff; "/V1/PLUS"
Global variables:
  nfp = 1
  nfx = 1
  nfn = 9
  nft = 5
  nfsw = 1
  vin1 = -600m
  vin2 = -20m
  t_per = 200p
  cff = 5f
  vcm = 600m
