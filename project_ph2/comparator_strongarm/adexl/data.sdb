ADE simulation setup
Run mode: Single Run, Sweeps and Corners
Tests:
  project_ph2:comparator_strongarm:1: project_ph2/comparator_strongarm/schematic, simulator spectre
    Outputs: /clk; vm+_curr; vm-_curr; /X6/D; vo_diff
Global variables:
  nfn = 1
  nfp = 1
  vin = 20m
  nfsw = {Exclusion List}0.5{Exclusion List}{From/To}Linear:1:1:10{From/To}
